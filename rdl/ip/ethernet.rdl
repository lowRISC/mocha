/* Copyright lowRISC contributors.
 * Licensed under the Apache License, Version 2.0; see LICENSE for details.
 * SPDX-License-Identifier: Apache-2.0
 */

`include "udp.rdl"

addrmap ethernet {
    desc = "Ethernet peripheral. 64-bit data, 64-bit address bus interface.";

    reg {
        desc = "Current interrupt status. Level interrupts clear automatically when the source condition deasserts.";
        field {
            sw = r;
            hw = w;
            reset = 0x0;
            desc = "RX data buffer not empty (level).";
        } RX_NOT_EMPTY[0:0];
        field {
            sw = r;
            hw = w;
            reset = 0x0;
            desc = "RX descriptor table almost full (level).";
        } RX_TABLE_ALMOST_FULL[1:1];
        field {
            sw = r;
            hw = w;
            reset = 0x0;
            desc = "RX descriptor table full (level).";
        } RX_TABLE_FULL[2:2];
        field {
            sw = r;
            hw = w;
            reset = 0x0;
            desc = "RX data buffer almost full (level).";
        } RX_BUF_ALMOST_FULL[3:3];
        field {
            sw = rw;
            onwrite = woclr;
            hw = rw;
            reset = 0x0;
            desc = "A packet was lost (sticky). Write 1 to clear.";
        } PACKET_LOST[4:4];
        field {
            sw = rw;
            onwrite = woclr;
            hw = rw;
            reset = 0x0;
            desc = "TX done (sticky). Write 1 to clear.";
        } TX_DONE[5:5];
        field {
            sw = rw;
            onwrite = woclr;
            hw = rw;
            reset = 0x0;
            desc = "Manual IRQ (sticky). Set by writing 1 to INTR_TEST.SET_MANUAL_IRQ. Write 1 to clear.";
        } MANUAL_IRQ[6:6];
    } INTR_STATE @ 0x800;

    reg {
        desc = "Per-source interrupt enable mask. 1 = enabled, 0 = masked.";
        field {
            sw = rw;
            hw = r;
            reset = 0x0;
            desc = "Enable interrupt when !!INTR_STATE.rx_not_empty is set.";
        } RX_NOT_EMPTY[0:0];
        field {
            sw = rw;
            hw = r;
            reset = 0x0;
            desc = "Enable interrupt when !!INTR_STATE.rx_table_almost_full is set.";
        } RX_TABLE_ALMOST_FULL[1:1];
        field {
            sw = rw;
            hw = r;
            reset = 0x0;
            desc = "Enable interrupt when !!INTR_STATE.rx_table_full is set.";
        } RX_TABLE_FULL[2:2];
        field {
            sw = rw;
            hw = r;
            reset = 0x0;
            desc = "Enable interrupt when !!INTR_STATE.rx_buf_almost_full is set.";
        } RX_BUF_ALMOST_FULL[3:3];
        field {
            sw = rw;
            hw = r;
            reset = 0x0;
            desc = "Enable interrupt when !!INTR_STATE.packet_lost is set.";
        } PACKET_LOST[4:4];
        field {
            sw = rw;
            hw = r;
            reset = 0x0;
            desc = "Enable interrupt when !!INTR_STATE.tx_done is set.";
        } TX_DONE[5:5];
        field {
            sw = rw;
            hw = r;
            reset = 0x0;
            desc = "Enable interrupt when !!INTR_STATE.manual_irq is set.";
        } MANUAL_IRQ[6:6];
    } INTR_MASK @ 0x804;

    reg {
        desc = "Interrupt test register.";
        field {
            sw = w;
            hw = r;
            reset = 0x0;
            desc = "Write 1 to set the manual_irq sticky bit in INTR_STATE.";
        } SET_MANUAL_IRQ[0:0];
    } INTR_TEST @ 0x808;

    reg {
        desc = "Control register.";
        field {
            sw = rw;
            hw = r;
            reset = 0x0;
            desc = "Promiscuous mode. 0 = filter by local MAC address; 1 = capture all received frames.";
        } PROMISCUOUS_MODE[0:0];
        field {
            sw = rw;
            hw = r;
            reset = 0x0;
            desc = "Internal loopback enable. Loops TX frames back to the RX path (excluding MAC and PHY).";
        } LOOPBACK[1:1];
    } CTRL @ 0x810;

    reg {
        desc = "RX and TX status flags.";
        field {
            sw = r;
            hw = w;
            reset = 0x0;
            desc = "RX data buffer not empty.";
        } RX_NOT_EMPTY[0:0];
        field {
            sw = r;
            hw = w;
            reset = 0x0;
            desc = "RX descriptor table almost full.";
        } RX_TABLE_ALMOST_FULL[1:1];
        field {
            sw = r;
            hw = w;
            reset = 0x0;
            desc = "RX descriptor table full.";
        } RX_TABLE_FULL[2:2];
        field {
            sw = r;
            hw = w;
            reset = 0x0;
            desc = "RX data buffer almost full.";
        } RX_BUF_ALMOST_FULL[3:3];
        field {
            sw = r;
            hw = w;
            reset = 0x0;
            desc = "A packet was lost.";
        } PACKET_LOST[4:4];
        field {
            sw = r;
            hw = w;
            reset = 0x0;
            desc = "TX busy. Asserted while a frame is being transmitted.";
        } TX_BUSY[7:7];
        field {
            sw = r;
            hw = w;
            reset = 0x0;
            desc = "Number of packets currently stored in the RX data buffer.";
        } N_PACKETS_IN_RX_BUF[11:8];
    } STATUS @ 0x814;

    reg {
        desc = "Lower 32 bits of the local MAC address.";
        field {
            sw = rw;
            hw = r;
            reset = 0x0;
            desc = "MAC address bits [31:0].";
        } MAC_LO[31:0];
    } MACLO @ 0x818;

    reg {
        desc = "Upper 16 bits of the local MAC address.";
        field {
            sw = rw;
            hw = r;
            reset = 0x0;
            desc = "MAC address bits [47:32].";
        } MAC_HI[15:0];
    } MACHI @ 0x81C;

    reg {
        desc = "TX control register. Writing this register starts a transmission.";
        field {
            sw = rw;
            hw = r;
            reset = 0x0;
            desc = "Number of bytes to transmit from the TX data buffer.";
        } TX_PACKET_LEN[10:0];
    } TX_CTRL @ 0x820;

    reg {
        desc = "RX descriptor table pop register.";
        field {
            sw = w;
            hw = r;
            reset = 0x0;
            desc = "Write 1 to pop the oldest entry from the RX descriptor table.";
        } POP[0:0];
    } RX_POP @ 0x828;

    reg {
        desc = "Bit-bang MDIO/MDC interface control register.";
        field {
            sw = rw;
            hw = r;
            reset = 0x0;
            desc = "MDC clock output.";
        } MDIO_CLK[0:0];
        field {
            sw = rw;
            hw = r;
            reset = 0x0;
            desc = "MDIO output data.";
        } MDIO_O[1:1];
        field {
            sw = rw;
            hw = r;
            reset = 0x0;
            desc = "MDIO output enable.";
        } MDIO_OEN[2:2];
        field {
            sw = r;
            hw = w;
            desc = "MDIO input data sampled from the PHY.";
        } MDIO_I[3:3];
    } MDIO_CTRL @ 0x82C;

    external mem {
        desc = "TX data buffer. 256 * 64-bit words (2 KiB).";
        memwidth = 0x40;
        mementries = 0x100;
        sw = w;
    } TX_DATA_BUF @ 0x1000;

    external mem {
        desc = "RX data buffer. 1024 * 64-bit words (8 KiB).";
        memwidth = 0x40;
        mementries = 0x400;
        sw = r;
    } RX_DATA_BUF @ 0x4000;

    external mem {
        desc = "RX descriptor table. 8 * 64-bit entries.";
        memwidth = 0x40;
        mementries = 0x8;
        sw = r;
    } RX_DESC_TABLE @ 0x6000;
};
